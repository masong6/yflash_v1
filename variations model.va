// VerilogA for Yflash_variations, Yflash_model, stochastic model, veriloga

`include "constants.vams"
`include "disciplines.vams"

module yflash_model(src_read, src_inj, sub, dra);
inout  src_read, src_inj, dra, sub;
electrical src_inj, dra, sub;
electrical src_read;
integer prob_seed;
integer v_var_seed; //initial seed in order to produce pseudo random numbers
integer process_var_seed;
ground gnd;

//PARAMETERS
parameter real vth_init = 1;			//Initial value of Vth
parameter real CRprog = 0.48;
parameter real K_Cfr_45 = 5.1e-5;
parameter real K_Cfr_5 = 2.1e-4;			//values of bp45 & bp5 depend on the time it takes to switch the particular voltage. Dependent on device dynamics
parameter real mvt0 = 0.144765;	//Technology constant*VT fitted to room termparture
parameter real CR = 1;				//for Read mode
parameter real i0 = 1e-9;		//IDS in sub-threshold at VDS = 2V and Vth = 2V
parameter real prob_seed_in = 0;
parameter real v_var_seed_in = 0; 	// Seed for input voltage variation randomization
parameter real v_var_std = 0.01; // Variation for input voltage
parameter real process_var_std = 0;
parameter real process_var_seed_in = 0;
parameter real T = 25; //initial room temperature

//give a time step value of (resolution*1u) while performing the transient analysis
parameter real resolution = 1; 		//used to improve the output graph resolution (functionality)

// LOCAL VARIABLES
real vds;									//drain-source voltage
real vth; 									//state variable vth
real dvthdt;
real first_iter = 0;						//initialised to zero
real i;
real tau = 7e-7;
real time_step = 10e-6;
real randm;
real lambda;
real prob_t;
real align = 500000 ;
real v_var;
real iread ; 		//IDS in sub-threshold at VDS = 2V and Vth = 2V taking into account process variations of W, L and tox with distribution [0.8nA:1.1nA]
real mvt = mvt0*(T + 273)/298;									//output current

//////////////////// MAIN ////////////////////////
analog begin
		//initializing vth
		if(first_iter==0) begin
			vth = vth_init;
			v_var_seed = v_var_seed_in;
			process_var_seed = process_var_seed_in;
			first_iter = 1;
		end
//device behaviour as a memristor
//Includes programming(for 4.5V, 5V), erase(for 8V) and read for 2V
//Read mode -- subthreshold mode conduction
		if(V(dra,src_read)<= 2.0)begin
			v_var = V(dra,src_read) + $rdist_normal (v_var_seed, 0, v_var_std); //random noise on reading voltage
			iread = (i0 + $rdist_normal(process_var_seed, 0, process_var_std))*((mvt*mvt)/(mvt0*mvt0));
			i = iread*exp((v_var)/(mvt))*exp(-vth/mvt);
			dvthdt = 0;
			I(dra) <+ i;
			I(src_read) <+ -i;
		end
		lambda= 1/tau;
		prob_t = lambda*exp(-1*time_step/tau)/100000;

//Programming mode 4.5V short-channel
		if (V(dra,src_inj)== 4.5) begin
			v_var = V(dra,src_inj) + $rdist_normal (v_var_seed, 0, v_var_std); //random noise on programming voltage
			prob_seed = prob_seed_in;
			randm = $rdist_uniform(1, 0, 1);
			if (prob_t/5 >= randm) begin
				dvthdt = K_Cfr_45*(CRprog*v_var - vth);	//b45 = (K'(=uCoxW/2)/Cfr)*P(Ev), a45 = CRprog = 0.48
				dvthdt = dvthdt + sqrt(dvthdt)*prob_t/5;
			end
			I(dra, src_inj) <+ 0;
		end
//Programming mode 5V short-channel
		if (V(dra,src_inj) >= 4.9 && V(dra,src_inj) <= 5.1) begin
			v_var = V(dra,src_inj) + $rdist_normal (v_var_seed, 0, v_var_std); //random noise on programming voltage
			prob_seed = prob_seed_in;
			randm = $rdist_uniform(10, 0, 1);
			if (prob_t/5 >= randm) begin
				dvthdt = K_Cfr_5*(CRprog*v_var - vth);
				dvthdt = dvthdt + sqrt(dvthdt)*prob_t/5;
			end
			I(dra, src_inj) <+ 0;
		end
//Erase mode 8V
		if (V(src_inj,gnd) == 8) begin
			v_var = V(src_inj,gnd) + $rdist_normal (v_var_seed, 0, v_var_std); //random noise on erasing voltage
			prob_seed = prob_seed_in;
			randm = $rdist_uniform(1, 0, 1);
 			if (prob_t/5 >= randm) begin
				dvthdt = 4.6428e-4*(v_var - 7.0469-vth)*exp((-0.07)/(v_var - 7.0469-vth)); //constants = A/(Cdep*tox), B*tox
				dvthdt = dvthdt + sqrt(dvthdt)*prob_t/5;
			end
		end

//defining window function b/w vth = [1,2]V
if(vth < 1.0 || vth > 2.0)begin
	dvthdt = 0;
end
vth = vth + resolution*dvthdt;
//Updating output nodes
		I(sub) <+ 0;
dvthdt = 0;
end
endmodule
